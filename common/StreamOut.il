procedure(StreamOut()
let((cv gds_d)
	cv=geGetEditCellView()
	gds_d= strcat("~/gds/" cv~>cellName)
	unless(isDir(gds_d) sh(strcat("mkdir -p " gds_d)))
	unless(cv~>cellViewType=="maskLayout"
		warn("%L %L %L is not layout view\n"
		cv~>libName cv~>cellName cv~>viewName)
		return(nil)
		)
	xstSetField("virtualMemory" "true")
	xstSetField("library" cv->libName)
	xstSetField("ToPCell" cv->cellName)
	xstSetField("View" cv->viewName)
	xstSetField("strmFile" strcat(gds_d "/" cv~>cellName ".gds"))
	xstSetField("replaceBusBitChar" "true")
	xstSetField("showCompletionMsgBox" "false")
	xstOutDoTranslate()
	)
)
